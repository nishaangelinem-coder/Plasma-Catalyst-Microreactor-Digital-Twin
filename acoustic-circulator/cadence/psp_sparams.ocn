;; OCEAN script: PSS + PSP periodic S-parameters of the STM acoustic circulator (series-mode junction)
;; Usage in Virtuoso CIW:  load("psp_sparams.ocn")
simulator( 'spectre )
design( "circulator_lib" "tb_circulator_core" "schematic" )
resultsDir( "./psp_results" )
modelFile( '("/path/to/pdk/models/spectre/toplevel.scs" "tt") )
desVar( "fm" 4.000000e+07 )
desVar( "Csh" 3.9105e-12 )
desVar( "Csw" 7.7785e-12 )
desVar( "Wsw" "1865u" )
analysis( 'pss ?fund "fm" ?harms "50" ?errpreset "conservative" ?tstab "500n" ?maxacfreq "12G" )
analysis( 'psp ?sweeptype "absolute" ?start "0.9G" ?stop "1.1G" ?lin "201"
              ?ports list("/PORT1" "/PORT2" "/PORT3") ?portharmsvec list("0" "0" "0") ?donoise "no" )
option( 'reltol 1e-4 )
temp( 27 )
run()
selectResult( 'psp )
s21 = dB20( spm( 2 1 ) )   s32 = dB20( spm( 3 2 ) )   s13 = dB20( spm( 1 3 ) )
s12 = dB20( spm( 1 2 ) )   s23 = dB20( spm( 2 3 ) )   s31 = dB20( spm( 3 1 ) )
s11 = dB20( spm( 1 1 ) )   s22 = dB20( spm( 2 2 ) )   s33 = dB20( spm( 3 3 ) )
plot( s21 s12 s11 ?expr list("S21 (fwd)" "S12 (rev)" "S11") )
il  = -value( s21 1.0e9 )
iso = -value( s12 1.0e9 )
rl  = -value( s11 1.0e9 )
printf( "IL = %.2f dB  ISO = %.2f dB  RL = %.2f dB at 1 GHz\n" il iso rl )
bw = bandwidth( -s12 20 "pass" )
printf( "20-dB isolation bandwidth = %.2f MHz\n" bw/1e6 )
ocnPrint( ?output "./psp_results/sparams.csv" ?numberNotation 'scientific s21 s12 s11 s32 s23 s22 s13 s31 s33 )
selectResult( 'pss_td )
pdrv = -average( IT("/Vdd") ) * 1.2
printf( "Pump power (phase generator + drivers) = %.3f mW\n" pdrv*1e3 )
