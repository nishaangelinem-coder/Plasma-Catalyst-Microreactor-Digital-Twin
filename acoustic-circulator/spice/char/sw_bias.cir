* switch with S/D biased at VB: on-resistance at Vgs=1.2-VB, off-state series C at Vgs=-VB (W=1000um)
.include ../../models/cmos65_bsim4.lib
.param vb=0.3 rg=3k rb=20k cdnw=0.1p
Vg gdrv 0 dc 1.2
Rg gdrv g {rg}
Rb b s {rb}
Cdnw b 0 {cdnw}
Vd d 0 dc {vb} ac 1
Vs s 0 dc {vb} ac 0
M1 d g s b nmos65 w=1000u l=65n nf=200
.control
foreach vgv 1.2 0
  alter Vg dc = $vgv
  alter Vd ac = 1
  alter Vs ac = 0
  ac lin 1 1G 1G
  let y11 = -i(Vd)
  alter Vd ac = 0
  alter Vs ac = 1
  ac lin 1 1G 1G
  let y12 = -i(Vd)
  let y22 = -i(Vs)
  print $vgv
  print y12
  print y22
end
.endc
.end
