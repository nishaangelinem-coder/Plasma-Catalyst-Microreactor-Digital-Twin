// sustaining_amp.scs -- transmission-mode differential sustaining amplifier
// (common-gate cascode TIA with LC tank + resistor-loaded gain stage + SF drivers).
// Element values come from design_values.scs (generated by sim/ngspice_osc.py).
simulator lang=spectre

subckt sustaining_amp (p1 n1 p2 n2 vdd gnd)
parameters polarity=-1
    // ---------- bias ----------
    Vb1 (vb1 gnd) vsource dc=vb1
    Vb2 (vb2 gnd) vsource dc=vb2
    Vbc (vbc gnd) vsource dc=1.30
    Vbn (vbn gnd) vsource dc=vbn
    // ---------- port-2 resonating inductor + pad parasitics ----------
    // centre-tapped: the tap carries the CG bias so tail noise is common-mode
    Lina (p2 ct) ind_q L=Lin/2 Q=QL
    Linb (n2 ct) ind_q L=Lin/2 Q=QL
    Cct  (ct gnd) capacitor c=10p
    Cpa  (p2 gnd) capacitor c=60f
    Cpb  (n2 gnd) capacitor c=60f
    // ---------- stage 1: common-gate cascode pair, LC tank ----------
    M1a  (d1ai vb1 p2 gnd) nmos_1p8 w=W1 l=Lg
    M1b  (d1bi vb1 n2 gnd) nmos_1p8 w=W1 l=Lg
    M1ca (d1a vbc d1ai gnd) nmos_1p8 w=W1 l=Lg
    M1cb (d1b vbc d1bi gnd) nmos_1p8 w=W1 l=Lg
    Mt1  (ct vbn gnd gnd) nmos_1p8 w=2*Wt1 l=360n
    Lta  (vdd d1a) ind_q L=Lt/2 Q=QL
    Ltb  (vdd d1b) ind_q L=Lt/2 Q=QL
    Ct   (d1a d1b) capacitor c=Ct          // part of this is the trim varactor
    // ---------- stage 2: resistor-loaded differential pair ----------
    // polarity = +1 : d1a->g2a ; polarity = -1 : d1b->g2a (loop inversion)
    Cc2a (d1a g2x) capacitor c=2p
    Cc2b (d1b g2y) capacitor c=2p
    Rpa  (g2x g2a) resistor r=(polarity>0 ? 1m : 1T)
    Rpb  (g2x g2b) resistor r=(polarity>0 ? 1T : 1m)
    Rpc  (g2y g2b) resistor r=(polarity>0 ? 1m : 1T)
    Rpd  (g2y g2a) resistor r=(polarity>0 ? 1T : 1m)
    Rb2a (g2a vb2) resistor r=5k
    Rb2b (g2b vb2) resistor r=5k
    M2a  (d2a g2a s2 gnd) nmos_1p8 w=W2 l=Lg
    M2b  (d2b g2b s2 gnd) nmos_1p8 w=W2 l=Lg
    Mt2  (s2 vbn gnd gnd) nmos_1p8 w=Wt2 l=360n
    RL2a (vdd d2a) resistor r=RL2
    RL2b (vdd d2b) resistor r=RL2
    Vbp  (vbp gnd) vsource dc=0.90
    M5a  (d2a vbp vdd vdd) pmos_1p8 w=Wp2 l=360n      // PMOS current-source assist
    M5b  (d2b vbp vdd vdd) pmos_1p8 w=Wp2 l=360n
    // ---------- stage 3: second resistor-loaded differential pair ----------
    Cc3a (d2a g3a) capacitor c=2p
    Cc3b (d2b g3b) capacitor c=2p
    Rb3a (g3a vb2) resistor r=5k
    Rb3b (g3b vb2) resistor r=5k
    M3a  (d3a g3a s3 gnd) nmos_1p8 w=W3 l=Lg
    M3b  (d3b g3b s3 gnd) nmos_1p8 w=W3 l=Lg
    Mt3  (s3 vbn gnd gnd) nmos_1p8 w=Wt3 l=360n
    RL3a (vdd d3a) resistor r=RL3
    RL3b (vdd d3b) resistor r=RL3
    // ---------- stage 4: source-follower drivers ----------
    M4a  (vdd d3a oa gnd) nmos_1p8 w=W4 l=Lg
    M4b  (vdd d3b ob gnd) nmos_1p8 w=W4 l=Lg
    Mt4a (oa vbn gnd gnd) nmos_1p8 w=Wt4 l=360n
    Mt4b (ob vbn gnd gnd) nmos_1p8 w=Wt4 l=360n
    Cca  (oa p1) capacitor c=10p
    Ccb  (ob n1) capacitor c=10p
    // ---------- port-1 resonating inductor ----------
    Lout (p1 n1) ind_q L=Lout Q=QL
    Rdc  (p1 gnd) resistor r=10k
ends sustaining_amp
