;; run_pvt_corners.ocn -- process corners x temperature x supply
;; writes cadence/results/pvt_corners.csv : corner,temp,vdd,f_osc,PN1k,PN100k,I_dc
simulator( 'spectre )
design( "../netlists/ring_osc_tb.scs" )
resultsDir( "../results/psf_pvt" )
fp = outfile( "../results/pvt_corners.csv" "w" )
fprintf( fp "corner,temp_C,vdd_V,f_osc_Hz,PN_1k_dBcHz,PN_100k_dBcHz,I_dc_A\n" )
foreach( corner list("tt" "ss" "ff" "sf" "fs")
  modelFile( list( getShellEnvVar("PDK_MODEL_FILE") corner ) )
  foreach( T list(-40 27 85)
    foreach( vs list(1.62 1.8 1.98)
      desVar( "vdd_v" vs )
      temp( T )
      analysis('pss ?fund "f0" ?harms "15" ?tstab "60u" ?errpreset "moderate" ?method "shooting")
      analysis('pnoise ?sweeptype "relative" ?relharmnum "1" ?start "100" ?stop "10M" ?dec "10"
               ?maxsideband "15" ?noisetype "pm" ?p "p1" ?n "n1")
      run()
      selectResult( 'pnoise )
      pn = phaseNoise( 1 "pss_fd" ?result "pnoise" )
      selectResult( 'pss_fd )
      fprintf( fp "%s,%g,%g,%g,%g,%g,%g\n" corner T vs getData("fund" ?result "pss_fd")
               value(pn 1e3) value(pn 100e3) value( mag( i("Vdd:p" ?result "pss_fd") ) 0 ) )
    )))
close( fp )
