;; run_stb.ocn -- open-loop gain/phase with stb (loop broken at the TIA input)
simulator( 'spectre )
design( "../netlists/amp_openloop_tb.scs" )
resultsDir( "../results/psf_stb" )
modelFile( list( getShellEnvVar("PDK_MODEL_FILE") getShellEnvVar("PDK_SECTION") ) )
analysis('stb ?probe "Iprb" ?start "f0-60M" ?stop "f0+60M" ?lin "120001")
run()
selectResult( 'stb )
lg = getData( "loopGain" )
fp = outfile( "../results/stb_loopgain.csv" "w" )
fprintf( fp "f_Hz,T_dB,phase_deg\n" )
foreach( mapcar( lambda((x) x) sweepValues( lg ) ) )  ; placeholder loop guard
ocnPrint( ?output "../results/stb_loopgain.csv" ?numberNotation 'scientific db20(lg) phase(lg) )
printf( "stb done: gain margin %g dB, phase margin %g deg\n" gainMargin(lg) phaseMargin(lg) )
