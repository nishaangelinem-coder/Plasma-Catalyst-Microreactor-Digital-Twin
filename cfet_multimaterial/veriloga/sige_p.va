// =====================================================================================
//  sige_p.va  --  UCM-CFET compact model, SiGe nanosheet p-FET
//  Platform tag: SiGe   Transport: dd
//  Generated by sim/gen_veriloga.py on 2026-10-05 from sim/platforms.py
//  Terminals: d g s b   (b is a reference terminal; tie to s in circuits)
//  Internal : di si (series resistance), tj (self-heating temperature rise, K)
//  Equations: doc/model_spec.md  -- identical to sim/ucm.py and netlists/ngspice/ucm_cfet.lib
// =====================================================================================
`include "constants.vams"
`include "disciplines.vams"
`define P_G0 (4.0*`P_Q*`P_Q/`P_H)      // Landauer conductance of one CNT (2 spins x 2 valleys)

module sige_p(d, g, s, b);
inout d, g, s, b;
electrical d, g, s, b;
electrical di, si;        // internal drain / source
electrical tj;            // temperature rise node (V == K)

parameter integer TYPE = -1 from [-1:1];   // +1 n-type, -1 p-type (fixed for this cell)
parameter real W = 1e-07;  // effective channel width [m] (ignored for nanosheet devices: W = NNS*2*(WNS+TNS))
parameter real L = 1.6e-08;  // gate length [m]
parameter real NNS = 3.0;  // number of stacked nanosheets (0 = planar/2D/CNT/GaN)
parameter real WNS = 2e-08;  // nanosheet width [m]
parameter real TNS = 5e-09;  // nanosheet thickness [m]
parameter real VTH0 = 0.3618850198538636;  // threshold voltage at TNOM, VDS->0 [V]
parameter real N0 = 1.20375874333818;  // subthreshold ideality factor
parameter real ETA = 0.05746351439526155;  // DIBL coefficient [V/V]
parameter real MU0 = 0.007607751389240996;  // low-field mobility at TNOM [m^2/Vs]
parameter real COX = 0.043;  // gate dielectric capacitance per area [F/m^2]
parameter real VSAT = 224999.99999999997;  // saturation velocity [m/s]
parameter real LAMBDA = 0.2999999999999997;  // channel-length-modulation / output-conductance factor [1/V]
parameter real RSW = 5.480881324630727e-05;  // source series resistance x width [Ohm*m]
parameter real RDW = 5.480881324630727e-05;  // drain series resistance x width [Ohm*m]
parameter real CGSO = 3.2e-10;  // gate-source overlap/fringe capacitance per width [F/m]
parameter real CGDO = 3.2e-10;  // gate-drain overlap/fringe capacitance per width [F/m]
parameter real TNOM = 300.0;  // nominal temperature [K]
parameter real MUEXP = 1.2;  // mobility temperature exponent
parameter real KVTH = -0.001;  // threshold temperature coefficient [V/K]
parameter real CQ = 1.0e9;  // quantum capacitance per area [F/m^2] (2D/CNT), large = off
parameter real DIT = 0.0;  // interface trap density [1/(m^2 eV)]
parameter real RC = 0.0;  // contact resistance x width [Ohm*m] (2D/CNT)
parameter real RTH = 0.0;  // thermal resistance [K/W] (GaN self-heating, 0 = off)
parameter real CTH = 1e-12;  // thermal capacitance [J/K]
parameter real DCNT = 0.0;  // CNT density [tubes/m]
parameter real FMET = 0.0;  // metallic CNT fraction
parameter real TTR = 0.0;  // quasi-ballistic transmission probability
parameter real ALPHA = 1.0;  // gate coupling efficiency (CNT)

// ---------------------------------------------------------------- local variables -----
real weff, tamb, tdev, vt, cox_eff, n, vth_t, mu_t;
real vgs, vds, vgd, vds_abs, vth_eff;
real vov, vsatv, vdsat, beta, isat, ids;
real eta_s, eta_d, itube, ntube, gmet;
real qch, qgs, qgd, rs, rd, pdiss;

analog function real softplus;      // ln(1+exp(x)) without overflow, C-infinity
    input x; real x;
    begin
        if (x > 40.0) softplus = x; else softplus = ln(1.0 + exp(x));
    end
endfunction

analog begin
    // ---- geometry & temperature ------------------------------------------------------
    if (NNS > 0) weff = NNS*2.0*(WNS + TNS); else weff = W;
    tamb    = $temperature;
    tdev    = tamb + V(tj);                              // V(tj) = 0 unless RTH > 0
    if (tdev < tamb - 150.0) tdev = tamb - 150.0;        // numerical clamp of the temperature rise
    if (tdev > tamb + 1500.0) tdev = tamb + 1500.0;      // (keeps Newton iterations physical)
    vt      = `P_K*tdev/`P_Q;
    cox_eff = COX*CQ/(COX + CQ);                        // series quantum capacitance
    n       = N0*(1.0 + `P_Q*DIT/COX);                   // trap-limited ideality
    vth_t   = VTH0 + KVTH*(tdev - TNOM);
    if (MU0 > 0.0) mu_t = MU0*pow(tdev/TNOM, -MUEXP); else mu_t = 0.0;
    rs = RSW/weff;  rd = RDW/weff;

    // ---- terminal voltages in the n-type convention ----------------------------------
    vgs = TYPE*V(g, si);
    vds = TYPE*V(di, si);
    vgd = TYPE*V(g, di);
    vds_abs = sqrt(vds*vds + 1.0e-6);
    vth_eff = vth_t - ETA*vds_abs;                       // DIBL

    // ---- drift-diffusion with velocity saturation -----------------------------------
    vov    = 2.0*n*vt*softplus((vgs - vth_eff)/(2.0*n*vt));   // EKV-type smooth overdrive
    vsatv  = VSAT*L/mu_t;                                      // velocity-saturation voltage
    vdsat  = vov/(1.0 + vov/vsatv);
    beta   = mu_t*cox_eff*weff/L;
    isat   = beta*vov*vov/(2.0*(1.0 + vov/vsatv));
    ids    = isat*tanh(2.0*vds/(vdsat + 1.0e-9))*(1.0 + LAMBDA*vds_abs);

    // ---- series resistances ------------------------------------------------------------
    V(d, di) <+ I(d, di)*rd;
    V(s, si) <+ I(s, si)*rs;

    // ---- channel current -----------------------------------------------------------------
    I(di, si) <+ TYPE*ids;

    // ---- charge-conserving terminal charges: Qg = Qgs + Qgd, Qs = -Qgs, Qd = -Qgd --------
    qch = 0.5*weff*L*cox_eff;
    qgs = qch*2.0*n*vt*softplus((vgs - vth_t)/(2.0*n*vt)) + CGSO*weff*vgs;
    qgd = qch*2.0*n*vt*softplus((vgd - vth_t)/(2.0*n*vt)) + CGDO*weff*vgd;
    I(g, si) <+ TYPE*ddt(qgs);
    I(g, di) <+ TYPE*ddt(qgd);

    // ---- self-heating (GaN): Tdev = Tamb + RTH*Pdiss with thermal time constant RTH*CTH --
    pdiss = ids*vds;
    if (RTH > 0.0) begin
        I(tj) <+ -pdiss;
        I(tj) <+ V(tj)/RTH;
        I(tj) <+ ddt(CTH*V(tj));
    end else begin
        V(tj) <+ 0.0;
    end
    // body terminal: reference only (no current)
    I(b, si) <+ 0.0;
end
endmodule
