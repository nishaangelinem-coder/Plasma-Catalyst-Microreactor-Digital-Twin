// =============================================================================
// inv_cfet_sige.scs
// CFET-SiGe CFET inverter sub-circuit: sige_p stacked over gaa_n + CFET parasitics
// Hand-written Spectre netlist equivalent to CFET_LIB/inv_cfet_sige/schematic
// (cadence/skill/build_schematics.il). Included by tb_inv_cfet_sige.scs and ro5_cfet_sige.scs
// (not a top-level netlist: it carries no analyses and no top-level parameters).
// Units: SI throughout (m, V, A, F, Ohm; RSW/RDW/RC in Ohm*m, DIT in m^-2 eV^-1,
// DCNT in tubes/m, RTH in K/W, CTH in J/K). Suffixes: f=1e-15 p=1e-12 n=1e-9 u=1e-6.
// =============================================================================
simulator lang=spectre
global 0

// ---- compact models -----------------------------------------------------------
ahdl_include "../../veriloga/gaa_n.va"
ahdl_include "../../veriloga/sige_p.va"

// NOTE: no top-level `parameters` here -- the including testbench defines the
// design variables (Lg=16n NNSn=3 NNSp=3 WNS=20n RSW=1e-4 VTHN=0.25 VTHP=0.22 MUN=0.030 MUP=0.025)
// and passes them to every instance; duplicate top-level definitions would be
// rejected by Spectre.

// -------------------------------------------------------------------------------
// inv_cfet_sige (in out vdd vss)
//
//            vdd ---- s,b  MP (sige_p)  d ---- pd ---[Rlocal_p]---+
//   in ---- g                                                        |-- out --[Cout]-- vss
//            vss ---- s,b  MN (gaa_n)  d ---- nd ---[Rlocal_n]---+
//                                 [Cstack] between pd and nd (vertical n/p stack)
//
// CFET parasitics (mid-range defaults of the brief):
//   CSTACK  stacked-drain coupling capacitance    0.05f
//   COUT    output / local interconnect capacitance 0.3f
//   RLOCAL  local via / drain-to-output resistance  10 Ohm (one per device)
// The device variables are SUBCIRCUIT parameters (numeric nominal defaults) so
// that Spectre `mismatch` statistics (cadence/ade/mc_statistics.scs) sample them
// per inverter instance; the testbench passes VTHN=VTHN etc. so the global
// `process` variation of the top-level parameter is inherited as well.
// -------------------------------------------------------------------------------
subckt inv_cfet_sige (in out vdd vss)
parameters CSTACK=0.05f COUT=0.3f RLOCAL=10 \
    Lg=16n NNSn=3 NNSp=3 WNS=20n RSW=1e-4 VTHN=0.25 VTHP=0.22 MUN=0.030 MUP=0.025
    MP (pd in vdd vdd) sige_p L=Lg NNS=NNSp WNS=WNS VTH0=VTHP MU0=MUP RSW=RSW RDW=RSW \
    W=1e-07 TNS=5e-09 N0=1.20376 ETA=0.0574635 COX=0.043 VSAT=225000 LAMBDA=0.3 CGSO=3.2e-10 CGDO=3.2e-10 TNOM=300 MUEXP=1.2 KVTH=-0.001 CQ=1e9 DIT=0 RC=0 RTH=0 CTH=1e-12 DCNT=0 FMET=0 TTR=0 ALPHA=1   // calibrated defaults (data/calibrated_params.json)
    MN (nd in vss vss) gaa_n L=Lg NNS=NNSn WNS=WNS VTH0=VTHN MU0=MUN RSW=RSW RDW=RSW \
    W=1e-07 TNS=5e-09 N0=1.14212 ETA=0.0458488 COX=0.043 VSAT=250000 LAMBDA=0.3 CGSO=3e-10 CGDO=3e-10 TNOM=300 MUEXP=1.3 KVTH=-0.0008 CQ=1e9 DIT=0 RC=0 RTH=0 CTH=1e-12 DCNT=0 FMET=0 TTR=0 ALPHA=1   // calibrated defaults (data/calibrated_params.json)
    Rlocal_p (pd out) resistor r=RLOCAL
    Rlocal_n (nd out) resistor r=RLOCAL
    Cstack   (pd nd)  capacitor c=CSTACK
    Cout     (out vss) capacitor c=COUT
ends inv_cfet_sige
