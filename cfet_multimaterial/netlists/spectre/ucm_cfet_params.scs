// ucm_cfet_params.scs -- calibrated UCM-CFET instance parameters (generated by sim/export_cadence_params.py)
// include with: include "ucm_cfet_params.scs"  then e.g.  Mn (d g s b) gaa_n L=L_gaa_n VTH0=VTH0_gaa_n ...
simulator lang=spectre
// gaa_n: Si nanosheet n-FET
parameters W_gaa_n=1e-07 L_gaa_n=1.6e-08 NNS_gaa_n=3 WNS_gaa_n=2e-08 TNS_gaa_n=5e-09 VTH0_gaa_n=0.34564595563211264 N0_gaa_n=1.1421153845705354 ETA_gaa_n=0.04584877940688493 MU0_gaa_n=0.007528408507140861 COX_gaa_n=0.043 VSAT_gaa_n=249999.99999999994 LAMBDA_gaa_n=0.29999999999941973 RSW_gaa_n=5.313652472144767e-05 RDW_gaa_n=5.313652472144767e-05 CGSO_gaa_n=3e-10 CGDO_gaa_n=3e-10 TNOM_gaa_n=300.0 MUEXP_gaa_n=1.3 KVTH_gaa_n=-0.0008 CQ_gaa_n=1000000000.0 DIT_gaa_n=0.0 RC_gaa_n=0.0 RTH_gaa_n=0.0 CTH_gaa_n=1e-12 DCNT_gaa_n=0.0 FMET_gaa_n=0.0 TTR_gaa_n=0.0 ALPHA_gaa_n=1.0
// gaa_p: Si nanosheet p-FET
parameters W_gaa_p=1e-07 L_gaa_p=1.6e-08 NNS_gaa_p=3 WNS_gaa_p=2e-08 TNS_gaa_p=5e-09 VTH0_gaa_p=0.35039028711436815 N0_gaa_p=1.1743322337856366 ETA_gaa_p=0.05135576586222777 MU0_gaa_p=0.005470607323216929 COX_gaa_p=0.043 VSAT_gaa_p=199999.99999999997 LAMBDA_gaa_p=0.29999999999999993 RSW_gaa_p=6.53622960206374e-05 RDW_gaa_p=6.53622960206374e-05 CGSO_gaa_p=3e-10 CGDO_gaa_p=3e-10 TNOM_gaa_p=300.0 MUEXP_gaa_p=1.1 KVTH_gaa_p=-0.0009 CQ_gaa_p=1000000000.0 DIT_gaa_p=0.0 RC_gaa_p=0.0 RTH_gaa_p=0.0 CTH_gaa_p=1e-12 DCNT_gaa_p=0.0 FMET_gaa_p=0.0 TTR_gaa_p=0.0 ALPHA_gaa_p=1.0
// sige_p: SiGe nanosheet p-FET
parameters W_sige_p=1e-07 L_sige_p=1.6e-08 NNS_sige_p=3 WNS_sige_p=2e-08 TNS_sige_p=5e-09 VTH0_sige_p=0.3618850198538636 N0_sige_p=1.20375874333818 ETA_sige_p=0.05746351439526155 MU0_sige_p=0.007607751389240996 COX_sige_p=0.043 VSAT_sige_p=224999.99999999997 LAMBDA_sige_p=0.2999999999999997 RSW_sige_p=5.480881324630727e-05 RDW_sige_p=5.480881324630727e-05 CGSO_sige_p=3.2e-10 CGDO_sige_p=3.2e-10 TNOM_sige_p=300.0 MUEXP_sige_p=1.2 KVTH_sige_p=-0.001 CQ_sige_p=1000000000.0 DIT_sige_p=0.0 RC_sige_p=0.0 RTH_sige_p=0.0 CTH_sige_p=1e-12 DCNT_sige_p=0.0 FMET_sige_p=0.0 TTR_sige_p=0.0 ALPHA_sige_p=1.0
// mos2_n: MoS2 monolayer n-FET
parameters W_mos2_n=1e-07 L_mos2_n=2e-08 NNS_mos2_n=0 WNS_mos2_n=2e-08 TNS_mos2_n=5e-09 VTH0_mos2_n=0.3432803820841683 N0_mos2_n=1.1777096206413327 ETA_mos2_n=0.069521146642635 MU0_mos2_n=0.005582317142940906 COX_mos2_n=0.0345 VSAT_mos2_n=149999.99999999997 LAMBDA_mos2_n=0.29999999999999966 RSW_mos2_n=0.0005 RDW_mos2_n=0.0005 CGSO_mos2_n=2e-10 CGDO_mos2_n=2e-10 TNOM_mos2_n=300.0 MUEXP_mos2_n=1.0 KVTH_mos2_n=-0.001 CQ_mos2_n=1.2 DIT_mos2_n=5000000000000000.0 RC_mos2_n=0.0005 RTH_mos2_n=0.0 CTH_mos2_n=1e-12 DCNT_mos2_n=0.0 FMET_mos2_n=0.0 TTR_mos2_n=0.0 ALPHA_mos2_n=1.0
// wse2_p: WSe2 monolayer p-FET
parameters W_wse2_p=1e-07 L_wse2_p=2e-08 NNS_wse2_p=0 WNS_wse2_p=2e-08 TNS_wse2_p=5e-09 VTH0_wse2_p=0.37998533114114613 N0_wse2_p=1.2385992721091221 ETA_wse2_p=0.07733655802238211 MU0_wse2_p=0.0063227701557911796 COX_wse2_p=0.0345 VSAT_wse2_p=119999.99999999999 LAMBDA_wse2_p=0.29999999999999943 RSW_wse2_p=0.0008 RDW_wse2_p=0.0008 CGSO_wse2_p=2e-10 CGDO_wse2_p=2e-10 TNOM_wse2_p=300.0 MUEXP_wse2_p=1.0 KVTH_wse2_p=-0.0011 CQ_wse2_p=1.1 DIT_wse2_p=1e+16 RC_wse2_p=0.0008 RTH_wse2_p=0.0 CTH_wse2_p=1e-12 DCNT_wse2_p=0.0 FMET_wse2_p=0.0 TTR_wse2_p=0.0 ALPHA_wse2_p=1.0
// cnt_n: CNT array n-FET
parameters W_cnt_n=1e-07 L_cnt_n=2e-08 NNS_cnt_n=0 WNS_cnt_n=2e-08 TNS_cnt_n=5e-09 VTH0_cnt_n=0.3766900348578691 N0_cnt_n=1.1607578164186496 ETA_cnt_n=0.045879324523318187 MU0_cnt_n=0.0 COX_cnt_n=0.02 VSAT_cnt_n=0.0 LAMBDA_cnt_n=3.2703279390373716e-16 RSW_cnt_n=5e-05 RDW_cnt_n=5e-05 CGSO_cnt_n=1.5e-10 CGDO_cnt_n=1.5e-10 TNOM_cnt_n=300.0 MUEXP_cnt_n=0.0 KVTH_cnt_n=-0.0006 CQ_cnt_n=0.05 DIT_cnt_n=0.0 RC_cnt_n=5e-05 RTH_cnt_n=0.0 CTH_cnt_n=1e-12 DCNT_cnt_n=250000000.0 FMET_cnt_n=1e-06 TTR_cnt_n=0.21641743773826608 ALPHA_cnt_n=0.859579177463305
// cnt_p: CNT array p-FET
parameters W_cnt_p=1e-07 L_cnt_p=2e-08 NNS_cnt_p=0 WNS_cnt_p=2e-08 TNS_cnt_p=5e-09 VTH0_cnt_p=0.3753490085250708 N0_cnt_p=1.1526851286062594 ETA_cnt_p=0.045817572013178 MU0_cnt_p=0.0 COX_cnt_p=0.02 VSAT_cnt_p=0.0 LAMBDA_cnt_p=2.9576589494601867e-18 RSW_cnt_p=6e-05 RDW_cnt_p=6e-05 CGSO_cnt_p=1.5e-10 CGDO_cnt_p=1.5e-10 TNOM_cnt_p=300.0 MUEXP_cnt_p=0.0 KVTH_cnt_p=-0.0006 CQ_cnt_p=0.05 DIT_cnt_p=0.0 RC_cnt_p=6e-05 RTH_cnt_p=0.0 CTH_cnt_p=1e-12 DCNT_cnt_p=250000000.0 FMET_cnt_p=1e-06 TTR_cnt_p=0.21489465071289973 ALPHA_cnt_p=0.8566930544290252
// gan_n: GaN 2DEG n-FET
parameters W_gan_n=1e-06 L_gan_n=1e-07 NNS_gan_n=0 WNS_gan_n=2e-08 TNS_gan_n=5e-09 VTH0_gan_n=0.35662308540409715 N0_gan_n=1.38941612441517 ETA_gan_n=0.03260623850774278 MU0_gan_n=0.030000000000000006 COX_gan_n=0.008 VSAT_gan_n=374999.999999996 LAMBDA_gan_n=0.1912578288774095 RSW_gan_n=0.00037420031073685925 RDW_gan_n=0.00037420031073685925 CGSO_gan_n=5e-10 CGDO_gan_n=5e-10 TNOM_gan_n=300.0 MUEXP_gan_n=1.5 KVTH_gan_n=-0.0015 CQ_gan_n=1000000000.0 DIT_gan_n=0.0 RC_gan_n=0.0 RTH_gan_n=150000.0 CTH_gan_n=3e-14 DCNT_gan_n=0.0 FMET_gan_n=0.0 TTR_gan_n=0.0 ALPHA_gan_n=1.0
// gan_p: p-GaN (projected) p-FET
parameters W_gan_p=3e-06 L_gan_p=1e-07 NNS_gan_p=0 WNS_gan_p=2e-08 TNS_gan_p=5e-09 VTH0_gan_p=0.35487625232984094 N0_gan_p=1.4330393601859386 ETA_gan_p=0.03682456337456 MU0_gan_p=0.0018873856438115792 COX_gan_p=0.008 VSAT_gan_p=124999.99999999997 LAMBDA_gan_p=0.08249722318274405 RSW_gan_p=0.001212720072885748 RDW_gan_p=0.001212720072885748 CGSO_gan_p=5e-10 CGDO_gan_p=5e-10 TNOM_gan_p=300.0 MUEXP_gan_p=1.0 KVTH_gan_p=-0.002 CQ_gan_p=1000000000.0 DIT_gan_p=0.0 RC_gan_p=0.0 RTH_gan_p=100000.0 CTH_gan_p=9e-14 DCNT_gan_p=0.0 FMET_gan_p=0.0 TTR_gan_p=0.0 ALPHA_gan_p=1.0
