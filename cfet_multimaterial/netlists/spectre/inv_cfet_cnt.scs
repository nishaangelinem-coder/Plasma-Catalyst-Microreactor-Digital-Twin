// =============================================================================
// inv_cfet_cnt.scs
// CFET-CNT CFET inverter sub-circuit: cnt_p stacked over cnt_n + CFET parasitics
// Hand-written Spectre netlist equivalent to CFET_LIB/inv_cfet_cnt/schematic
// (cadence/skill/build_schematics.il). Included by tb_inv_cfet_cnt.scs and ro5_cfet_cnt.scs
// (not a top-level netlist: it carries no analyses and no top-level parameters).
// Units: SI throughout (m, V, A, F, Ohm; RSW/RDW/RC in Ohm*m, DIT in m^-2 eV^-1,
// DCNT in tubes/m, RTH in K/W, CTH in J/K). Suffixes: f=1e-15 p=1e-12 n=1e-9 u=1e-6.
// =============================================================================
simulator lang=spectre
global 0

// ---- compact models -----------------------------------------------------------
ahdl_include "../../veriloga/cnt_n.va"
ahdl_include "../../veriloga/cnt_p.va"

// NOTE: no top-level `parameters` here -- the including testbench defines the
// design variables (Wn=100n Wp=100n Lg=15n VTHN=0.20 VTHP=0.22 DCNT=250e6 FMET=0.01 RCN=1e-4 RCP=1e-4)
// and passes them to every instance; duplicate top-level definitions would be
// rejected by Spectre.

// -------------------------------------------------------------------------------
// inv_cfet_cnt (in out vdd vss)
//
//            vdd ---- s,b  MP (cnt_p)  d ---- pd ---[Rlocal_p]---+
//   in ---- g                                                        |-- out --[Cout]-- vss
//            vss ---- s,b  MN (cnt_n)  d ---- nd ---[Rlocal_n]---+
//                                 [Cstack] between pd and nd (vertical n/p stack)
//
// CFET parasitics (mid-range defaults of the brief):
//   CSTACK  stacked-drain coupling capacitance    0.03f
//   COUT    output / local interconnect capacitance 0.3f
//   RLOCAL  local via / drain-to-output resistance  50 Ohm (one per device)
// The device variables are SUBCIRCUIT parameters (numeric nominal defaults) so
// that Spectre `mismatch` statistics (cadence/ade/mc_statistics.scs) sample them
// per inverter instance; the testbench passes VTHN=VTHN etc. so the global
// `process` variation of the top-level parameter is inherited as well.
// -------------------------------------------------------------------------------
subckt inv_cfet_cnt (in out vdd vss)
parameters CSTACK=0.03f COUT=0.3f RLOCAL=50 \
    Wn=100n Wp=100n Lg=15n VTHN=0.20 VTHP=0.22 DCNT=250e6 FMET=0.01 RCN=1e-4 RCP=1e-4
    MP (pd in vdd vdd) cnt_p W=Wp L=Lg VTH0=VTHP DCNT=DCNT FMET=FMET RC=RCP \
    NNS=0 WNS=2e-08 TNS=5e-09 N0=1.15269 ETA=0.0458176 MU0=0 COX=0.02 VSAT=0 LAMBDA=2.95766e-18 RSW=6e-05 RDW=6e-05 CGSO=1.5e-10 CGDO=1.5e-10 TNOM=300 MUEXP=0 KVTH=-0.0006 CQ=0.05 DIT=0 RTH=0 CTH=1e-12 TTR=0.214895 ALPHA=0.856693   // calibrated defaults (data/calibrated_params.json)
    MN (nd in vss vss) cnt_n W=Wn L=Lg VTH0=VTHN DCNT=DCNT FMET=FMET RC=RCN \
    NNS=0 WNS=2e-08 TNS=5e-09 N0=1.16076 ETA=0.0458793 MU0=0 COX=0.02 VSAT=0 LAMBDA=3.27033e-16 RSW=5e-05 RDW=5e-05 CGSO=1.5e-10 CGDO=1.5e-10 TNOM=300 MUEXP=0 KVTH=-0.0006 CQ=0.05 DIT=0 RTH=0 CTH=1e-12 TTR=0.216417 ALPHA=0.859579   // calibrated defaults (data/calibrated_params.json)
    Rlocal_p (pd out) resistor r=RLOCAL
    Rlocal_n (nd out) resistor r=RLOCAL
    Cstack   (pd nd)  capacitor c=CSTACK
    Cout     (out vss) capacitor c=COUT
ends inv_cfet_cnt
