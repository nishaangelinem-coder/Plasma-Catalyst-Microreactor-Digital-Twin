// =============================================================================
// inv_cfet_tmd.scs
// CFET-TMD CFET inverter sub-circuit: wse2_p stacked over mos2_n + CFET parasitics
// Hand-written Spectre netlist equivalent to CFET_LIB/inv_cfet_tmd/schematic
// (cadence/skill/build_schematics.il). Included by tb_inv_cfet_tmd.scs and ro5_cfet_tmd.scs
// (not a top-level netlist: it carries no analyses and no top-level parameters).
// Units: SI throughout (m, V, A, F, Ohm; RSW/RDW/RC in Ohm*m, DIT in m^-2 eV^-1,
// DCNT in tubes/m, RTH in K/W, CTH in J/K). Suffixes: f=1e-15 p=1e-12 n=1e-9 u=1e-6.
// =============================================================================
simulator lang=spectre
global 0

// ---- compact models -----------------------------------------------------------
ahdl_include "../../veriloga/mos2_n.va"
ahdl_include "../../veriloga/wse2_p.va"

// NOTE: no top-level `parameters` here -- the including testbench defines the
// design variables (Wn=100n Wp=200n Lg=20n VTHN=0.20 VTHP=0.25 MUN=5e-3 MUP=4e-3 RCN=5e-4 RCP=8e-4 DIT=1e16)
// and passes them to every instance; duplicate top-level definitions would be
// rejected by Spectre.

// -------------------------------------------------------------------------------
// inv_cfet_tmd (in out vdd vss)
//
//            vdd ---- s,b  MP (wse2_p)  d ---- pd ---[Rlocal_p]---+
//   in ---- g                                                        |-- out --[Cout]-- vss
//            vss ---- s,b  MN (mos2_n)  d ---- nd ---[Rlocal_n]---+
//                                 [Cstack] between pd and nd (vertical n/p stack)
//
// CFET parasitics (mid-range defaults of the brief):
//   CSTACK  stacked-drain coupling capacitance    0.03f
//   COUT    output / local interconnect capacitance 0.3f
//   RLOCAL  local via / drain-to-output resistance  50 Ohm (one per device)
// The device variables are SUBCIRCUIT parameters (numeric nominal defaults) so
// that Spectre `mismatch` statistics (cadence/ade/mc_statistics.scs) sample them
// per inverter instance; the testbench passes VTHN=VTHN etc. so the global
// `process` variation of the top-level parameter is inherited as well.
// -------------------------------------------------------------------------------
subckt inv_cfet_tmd (in out vdd vss)
parameters CSTACK=0.03f COUT=0.3f RLOCAL=50 \
    Wn=100n Wp=200n Lg=20n VTHN=0.20 VTHP=0.25 MUN=5e-3 MUP=4e-3 RCN=5e-4 RCP=8e-4 DIT=1e16
    MP (pd in vdd vdd) wse2_p W=Wp L=Lg VTH0=VTHP MU0=MUP RC=RCP DIT=DIT \
    NNS=0 WNS=2e-08 TNS=5e-09 N0=1.2386 ETA=0.0773366 COX=0.0345 VSAT=120000 LAMBDA=0.3 RSW=0.0008 RDW=0.0008 CGSO=2e-10 CGDO=2e-10 TNOM=300 MUEXP=1 KVTH=-0.0011 CQ=1.1 RTH=0 CTH=1e-12 DCNT=0 FMET=0 TTR=0 ALPHA=1   // calibrated defaults (data/calibrated_params.json)
    MN (nd in vss vss) mos2_n W=Wn L=Lg VTH0=VTHN MU0=MUN RC=RCN DIT=DIT \
    NNS=0 WNS=2e-08 TNS=5e-09 N0=1.17771 ETA=0.0695211 COX=0.0345 VSAT=150000 LAMBDA=0.3 RSW=0.0005 RDW=0.0005 CGSO=2e-10 CGDO=2e-10 TNOM=300 MUEXP=1 KVTH=-0.001 CQ=1.2 RTH=0 CTH=1e-12 DCNT=0 FMET=0 TTR=0 ALPHA=1   // calibrated defaults (data/calibrated_params.json)
    Rlocal_p (pd out) resistor r=RLOCAL
    Rlocal_n (nd out) resistor r=RLOCAL
    Cstack   (pd nd)  capacitor c=CSTACK
    Cout     (out vss) capacitor c=COUT
ends inv_cfet_tmd
