simulator lang=spectre
include "../../spectre/gaa_inv_tb.scs" section=models
include "../../spectre/gaa_nand2_tb.scs" section=models
subckt inverter (a y VDD VSS)
    X0 (a y VDD VSS) INV_GAA_X1
ends inverter
